// Design: Project_Lib1_sim/delay_chain_sim
simulator lang=spectre
global 0
include "/usr/local/cadence6/G-9FD-MIXED_MODE_RFCMOS13-1P8M-MMC_FSG_L130E_UM130FDKMFC0000OA-FDK-Ver.A02_PB/umc13mmrf/../Models/Spectre/l130e-rf-v171-control.scs"
include "/usr/local/cadence6/G-9FD-MIXED_MODE_RFCMOS13-1P8M-MMC_FSG_L130E_UM130FDKMFC0000OA-FDK-Ver.A02_PB/umc13mmrf/../Models/Spectre/L130E_LL12_V141.lib.scs" section=tt
include "/usr/local/cadence6/G-9FD-MIXED_MODE_RFCMOS13-1P8M-MMC_FSG_L130E_UM130FDKMFC0000OA-FDK-Ver.A02_PB/umc13mmrf/../Models/Spectre/L130E_HG_LVT33_BPW_V131.lib.scs" section=tt
include "/usr/local/cadence6/G-9FD-MIXED_MODE_RFCMOS13-1P8M-MMC_FSG_L130E_UM130FDKMFC0000OA-FDK-Ver.A02_PB/umc13mmrf/../Models/Spectre/L130E_HG_RVT33_BPW_V131.lib.scs" section=tt
include "/usr/local/cadence6/G-9FD-MIXED_MODE_RFCMOS13-1P8M-MMC_FSG_L130E_UM130FDKMFC0000OA-FDK-Ver.A02_PB/umc13mmrf/../Models/Spectre/L130E_HS12_BPW_V241.lib.scs" section=tt
include "/usr/local/cadence6/G-9FD-MIXED_MODE_RFCMOS13-1P8M-MMC_FSG_L130E_UM130FDKMFC0000OA-FDK-Ver.A02_PB/umc13mmrf/../Models/Spectre/L130E_HS_LVT12_BPW_V031.lib.scs" section=tt
include "/usr/local/cadence6/G-9FD-MIXED_MODE_RFCMOS13-1P8M-MMC_FSG_L130E_UM130FDKMFC0000OA-FDK-Ver.A02_PB/umc13mmrf/../Models/Spectre/L130E_BJT_V141.lib.scs" section=typ_BIP
include "/usr/local/cadence6/G-9FD-MIXED_MODE_RFCMOS13-1P8M-MMC_FSG_L130E_UM130FDKMFC0000OA-FDK-Ver.A02_PB/umc13mmrf/../Models/Spectre/L130E_HG_LVT33_V131.lib.scs" section=tt
include "/usr/local/cadence6/G-9FD-MIXED_MODE_RFCMOS13-1P8M-MMC_FSG_L130E_UM130FDKMFC0000OA-FDK-Ver.A02_PB/umc13mmrf/../Models/Spectre/L130E_HG_NVT33_v031.lib.scs" section=tt
include "/usr/local/cadence6/G-9FD-MIXED_MODE_RFCMOS13-1P8M-MMC_FSG_L130E_UM130FDKMFC0000OA-FDK-Ver.A02_PB/umc13mmrf/../Models/Spectre/L130E_HG_RVT33_V131.lib.scs" section=tt
include "/usr/local/cadence6/G-9FD-MIXED_MODE_RFCMOS13-1P8M-MMC_FSG_L130E_UM130FDKMFC0000OA-FDK-Ver.A02_PB/umc13mmrf/../Models/Spectre/L130E_HS12_V241.lib.scs" section=tt
include "/usr/local/cadence6/G-9FD-MIXED_MODE_RFCMOS13-1P8M-MMC_FSG_L130E_UM130FDKMFC0000OA-FDK-Ver.A02_PB/umc13mmrf/../Models/Spectre/L130E_HS_LVT12_V031.lib.scs" section=tt
include "/usr/local/cadence6/G-9FD-MIXED_MODE_RFCMOS13-1P8M-MMC_FSG_L130E_UM130FDKMFC0000OA-FDK-Ver.A02_PB/umc13mmrf/../Models/Spectre/L130E_HS_NVT12_V041.lib.scs" section=tt
include "/usr/local/cadence6/G-9FD-MIXED_MODE_RFCMOS13-1P8M-MMC_FSG_L130E_UM130FDKMFC0000OA-FDK-Ver.A02_PB/umc13mmrf/../Models/Spectre/MML130E_20f_MIMCAP_V011.lib.scs" section=typ
include "/usr/local/cadence6/G-9FD-MIXED_MODE_RFCMOS13-1P8M-MMC_FSG_L130E_UM130FDKMFC0000OA-FDK-Ver.A02_PB/umc13mmrf/../Models/Spectre/MML130E_15f_MIMCAP_V021.lib.scs" section=typ
include "/usr/local/cadence6/G-9FD-MIXED_MODE_RFCMOS13-1P8M-MMC_FSG_L130E_UM130FDKMFC0000OA-FDK-Ver.A02_PB/umc13mmrf/../Models/Spectre/MML130E_MIMCAP_V121.lib.scs" section=typ
include "/usr/local/cadence6/G-9FD-MIXED_MODE_RFCMOS13-1P8M-MMC_FSG_L130E_UM130FDKMFC0000OA-FDK-Ver.A02_PB/umc13mmrf/../Models/Spectre/mm130e_mom_v031.lib.scs" section=typ
include "/usr/local/cadence6/G-9FD-MIXED_MODE_RFCMOS13-1P8M-MMC_FSG_L130E_UM130FDKMFC0000OA-FDK-Ver.A02_PB/umc13mmrf/../Models/Spectre/MML130E_RES_V152.lib.scs" section=res_typ
include "/usr/local/cadence6/G-9FD-MIXED_MODE_RFCMOS13-1P8M-MMC_FSG_L130E_UM130FDKMFC0000OA-FDK-Ver.A02_PB/umc13mmrf/../Models/Spectre/L130E_SP12_V141.lib.scs" section=tt
include "/usr/local/cadence6/G-9FD-MIXED_MODE_RFCMOS13-1P8M-MMC_FSG_L130E_UM130FDKMFC0000OA-FDK-Ver.A02_PB/umc13mmrf/../Models/Spectre/L130E_DIODE_V151.mdl.scs"
include "/usr/local/cadence6/G-9FD-MIXED_MODE_RFCMOS13-1P8M-MMC_FSG_L130E_UM130FDKMFC0000OA-FDK-Ver.A02_PB/umc13mmrf/../Models/Spectre/VIL/1P8M2T/l_cr20k_rfvil_V031.lib.scs" section=typ
include "/usr/local/cadence6/G-9FD-MIXED_MODE_RFCMOS13-1P8M-MMC_FSG_L130E_UM130FDKMFC0000OA-FDK-Ver.A02_PB/umc13mmrf/../Models/Spectre/VIL/1P8M2T/l_nwcr20k_rfvil_V031.lib.scs" section=typ
include "/usr/local/cadence6/G-9FD-MIXED_MODE_RFCMOS13-1P8M-MMC_FSG_L130E_UM130FDKMFC0000OA-FDK-Ver.A02_PB/umc13mmrf/../Models/Spectre/VIL/1P8M2T/l_nwsqsk_rfvil_V031.lib.scs" section=typ
include "/usr/local/cadence6/G-9FD-MIXED_MODE_RFCMOS13-1P8M-MMC_FSG_L130E_UM130FDKMFC0000OA-FDK-Ver.A02_PB/umc13mmrf/../Models/Spectre/VIL/1P8M2T/l_nwsy20kct_rfvil_V031.lib.scs" section=typ
include "/usr/local/cadence6/G-9FD-MIXED_MODE_RFCMOS13-1P8M-MMC_FSG_L130E_UM130FDKMFC0000OA-FDK-Ver.A02_PB/umc13mmrf/../Models/Spectre/VIL/1P8M2T/l_nwsy20k_rfvil_V031.lib.scs" section=typ
include "/usr/local/cadence6/G-9FD-MIXED_MODE_RFCMOS13-1P8M-MMC_FSG_L130E_UM130FDKMFC0000OA-FDK-Ver.A02_PB/umc13mmrf/../Models/Spectre/VIL/1P8M2T/l_sqsk_rfvil_V031.lib.scs" section=typ
include "/usr/local/cadence6/G-9FD-MIXED_MODE_RFCMOS13-1P8M-MMC_FSG_L130E_UM130FDKMFC0000OA-FDK-Ver.A02_PB/umc13mmrf/../Models/Spectre/VIL/1P8M2T/l_sy20kct_rfvil_V031.lib.scs" section=typ
include "/usr/local/cadence6/G-9FD-MIXED_MODE_RFCMOS13-1P8M-MMC_FSG_L130E_UM130FDKMFC0000OA-FDK-Ver.A02_PB/umc13mmrf/../Models/Spectre/VIL/1P8M2T/l_sy20k_rfvil_V031.lib.scs" section=typ

// Project_Lib1/delay_chain/schematic
subckt delay_chain GND IN OUT VDD
    NM14 (OUT net0154 GND GND) n_12_hsl130e w=160.0n l=130.0n m=(1)*(1) nf=1 mis_flag=1 mf=(1)*(1)
    NM13 (net0154 net0152 GND GND) n_12_hsl130e w=160.0n l=130.0n m=(1)*(1) nf=1 mis_flag=1 mf=(1)*(1)
    NM12 (net0152 net0150 GND GND) n_12_hsl130e w=160.0n l=130.0n m=(1)*(1) nf=1 mis_flag=1 mf=(1)*(1)
    NM11 (net0150 net0148 GND GND) n_12_hsl130e w=160.0n l=130.0n m=(1)*(1) nf=1 mis_flag=1 mf=(1)*(1)
    NM10 (net0148 net0146 GND GND) n_12_hsl130e w=160.0n l=130.0n m=(1)*(1) nf=1 mis_flag=1 mf=(1)*(1)
    NM9 (net0146 net0144 GND GND) n_12_hsl130e w=160.0n l=130.0n m=(1)*(1) nf=1 mis_flag=1 mf=(1)*(1)
    NM8 (net0144 net0142 GND GND) n_12_hsl130e w=160.0n l=130.0n m=(1)*(1) nf=1 mis_flag=1 mf=(1)*(1)
    NM7 (net0142 net0140 GND GND) n_12_hsl130e w=160.0n l=130.0n m=(1)*(1) nf=1 mis_flag=1 mf=(1)*(1)
    NM6 (net0140 net0138 GND GND) n_12_hsl130e w=160.0n l=130.0n m=(1)*(1) nf=1 mis_flag=1 mf=(1)*(1)
    NM5 (net0138 net0135 GND GND) n_12_hsl130e w=160.0n l=130.0n m=(1)*(1) nf=1 mis_flag=1 mf=(1)*(1)
    NM4 (net0135 net0133 GND GND) n_12_hsl130e w=160.0n l=130.0n m=(1)*(1) nf=1 mis_flag=1 mf=(1)*(1)
    NM3 (net0133 net038 GND GND) n_12_hsl130e w=160.0n l=130.0n m=(1)*(1) nf=1 mis_flag=1 mf=(1)*(1)
    NM1 (net036 net033 GND GND) n_12_hsl130e w=160.0n l=130.0n m=(1)*(1) nf=1 mis_flag=1 mf=(1)*(1)
    NM2 (net038 net036 GND GND) n_12_hsl130e w=160.0n l=130.0n m=(1)*(1) nf=1 mis_flag=1 mf=(1)*(1)
    NM0 (net033 IN GND GND) n_12_hsl130e w=160.0n l=130.0n m=(1)*(1) nf=1 mis_flag=1 mf=(1)*(1)
    PM14 (OUT net0154 VDD VDD) p_12_hsl130e w=640.0n l=130.0n m=(1)*(1) nf=1 mis_flag=1 mf=(1)*(1)
    PM13 (net0154 net0152 VDD VDD) p_12_hsl130e w=640.0n l=130.0n m=(1)*(1) nf=1 mis_flag=1 mf=(1)*(1)
    PM12 (net0152 net0150 VDD VDD) p_12_hsl130e w=640.0n l=130.0n m=(1)*(1) nf=1 mis_flag=1 mf=(1)*(1)
    PM11 (net0150 net0148 VDD VDD) p_12_hsl130e w=640.0n l=130.0n m=(1)*(1) nf=1 mis_flag=1 mf=(1)*(1)
    PM10 (net0148 net0146 VDD VDD) p_12_hsl130e w=640.0n l=130.0n m=(1)*(1) nf=1 mis_flag=1 mf=(1)*(1)
    PM9 (net0146 net0144 VDD VDD) p_12_hsl130e w=640.0n l=130.0n m=(1)*(1) nf=1 mis_flag=1 mf=(1)*(1)
    PM8 (net0144 net0142 VDD VDD) p_12_hsl130e w=640.0n l=130.0n m=(1)*(1) nf=1 mis_flag=1 mf=(1)*(1)
    PM7 (net0142 net0140 VDD VDD) p_12_hsl130e w=640.0n l=130.0n m=(1)*(1) nf=1 mis_flag=1 mf=(1)*(1)
    PM6 (net0140 net0138 VDD VDD) p_12_hsl130e w=640.0n l=130.0n m=(1)*(1) nf=1 mis_flag=1 mf=(1)*(1)
    PM5 (net0138 net0135 VDD VDD) p_12_hsl130e w=640.0n l=130.0n m=(1)*(1) nf=1 mis_flag=1 mf=(1)*(1)
    PM4 (net0135 net0133 VDD VDD) p_12_hsl130e w=640.0n l=130.0n m=(1)*(1) nf=1 mis_flag=1 mf=(1)*(1)
    PM1 (net036 net033 VDD VDD) p_12_hsl130e w=(640nM)/(1) l=130.0n m=(1)*(1) nf=1 mis_flag=1 mf=(1)*(1)
    PM3 (net0133 net038 VDD VDD) p_12_hsl130e w=(640nM)/(1) l=130.0n m=(1)*(1) nf=1 mis_flag=1 mf=(1)*(1)
    PM2 (net038 net036 VDD VDD) p_12_hsl130e w=640.0n l=130.0n m=(1)*(1) nf=1 mis_flag=1 mf=(1)*(1)
    PM0 (net033 IN VDD VDD) p_12_hsl130e w=(640nM)/(1) l=130.0n m=(1)*(1) nf=1 mis_flag=1 mf=(1)*(1)
ends delay_chain

// Project_Lib1_sim/delay_chain_sim/schematic
I2 (0 in out net02) delay_chain
V1 (net02 0) vsource dc=1.2 type=dc
V0 (in 0) vsource type=pulse val0=0 val1=1.2 period=8n delay=2n rise=10p fall=10p width=4n
C0 (out 0) capacitor c=100.0f
simulatorOptions options temp=27
tran tran stop=24n
