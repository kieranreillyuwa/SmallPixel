// Design: Project_Lib1_sim/integrated_sim
simulator lang=spectre
global 0 vdd!
include "/usr/local/cadence6/G-9FD-MIXED_MODE_RFCMOS13-1P8M-MMC_FSG_L130E_UM130FDKMFC0000OA-FDK-Ver.A02_PB/umc13mmrf/../Models/Spectre/l130e-rf-v171-control.scs"
include "/usr/local/cadence6/G-9FD-MIXED_MODE_RFCMOS13-1P8M-MMC_FSG_L130E_UM130FDKMFC0000OA-FDK-Ver.A02_PB/umc13mmrf/../Models/Spectre/L130E_LL12_V141.lib.scs" section=tt
include "/usr/local/cadence6/G-9FD-MIXED_MODE_RFCMOS13-1P8M-MMC_FSG_L130E_UM130FDKMFC0000OA-FDK-Ver.A02_PB/umc13mmrf/../Models/Spectre/L130E_HG_LVT33_BPW_V131.lib.scs" section=tt
include "/usr/local/cadence6/G-9FD-MIXED_MODE_RFCMOS13-1P8M-MMC_FSG_L130E_UM130FDKMFC0000OA-FDK-Ver.A02_PB/umc13mmrf/../Models/Spectre/L130E_HG_RVT33_BPW_V131.lib.scs" section=tt
include "/usr/local/cadence6/G-9FD-MIXED_MODE_RFCMOS13-1P8M-MMC_FSG_L130E_UM130FDKMFC0000OA-FDK-Ver.A02_PB/umc13mmrf/../Models/Spectre/L130E_HS12_BPW_V241.lib.scs" section=tt
include "/usr/local/cadence6/G-9FD-MIXED_MODE_RFCMOS13-1P8M-MMC_FSG_L130E_UM130FDKMFC0000OA-FDK-Ver.A02_PB/umc13mmrf/../Models/Spectre/L130E_HS_LVT12_BPW_V031.lib.scs" section=tt
include "/usr/local/cadence6/G-9FD-MIXED_MODE_RFCMOS13-1P8M-MMC_FSG_L130E_UM130FDKMFC0000OA-FDK-Ver.A02_PB/umc13mmrf/../Models/Spectre/L130E_BJT_V141.lib.scs" section=typ_BIP
include "/usr/local/cadence6/G-9FD-MIXED_MODE_RFCMOS13-1P8M-MMC_FSG_L130E_UM130FDKMFC0000OA-FDK-Ver.A02_PB/umc13mmrf/../Models/Spectre/L130E_HG_LVT33_V131.lib.scs" section=tt
include "/usr/local/cadence6/G-9FD-MIXED_MODE_RFCMOS13-1P8M-MMC_FSG_L130E_UM130FDKMFC0000OA-FDK-Ver.A02_PB/umc13mmrf/../Models/Spectre/L130E_HG_NVT33_v031.lib.scs" section=tt
include "/usr/local/cadence6/G-9FD-MIXED_MODE_RFCMOS13-1P8M-MMC_FSG_L130E_UM130FDKMFC0000OA-FDK-Ver.A02_PB/umc13mmrf/../Models/Spectre/L130E_HG_RVT33_V131.lib.scs" section=tt
include "/usr/local/cadence6/G-9FD-MIXED_MODE_RFCMOS13-1P8M-MMC_FSG_L130E_UM130FDKMFC0000OA-FDK-Ver.A02_PB/umc13mmrf/../Models/Spectre/L130E_HS12_V241.lib.scs" section=tt
include "/usr/local/cadence6/G-9FD-MIXED_MODE_RFCMOS13-1P8M-MMC_FSG_L130E_UM130FDKMFC0000OA-FDK-Ver.A02_PB/umc13mmrf/../Models/Spectre/L130E_HS_LVT12_V031.lib.scs" section=tt
include "/usr/local/cadence6/G-9FD-MIXED_MODE_RFCMOS13-1P8M-MMC_FSG_L130E_UM130FDKMFC0000OA-FDK-Ver.A02_PB/umc13mmrf/../Models/Spectre/L130E_HS_NVT12_V041.lib.scs" section=tt
include "/usr/local/cadence6/G-9FD-MIXED_MODE_RFCMOS13-1P8M-MMC_FSG_L130E_UM130FDKMFC0000OA-FDK-Ver.A02_PB/umc13mmrf/../Models/Spectre/MML130E_20f_MIMCAP_V011.lib.scs" section=typ
include "/usr/local/cadence6/G-9FD-MIXED_MODE_RFCMOS13-1P8M-MMC_FSG_L130E_UM130FDKMFC0000OA-FDK-Ver.A02_PB/umc13mmrf/../Models/Spectre/MML130E_15f_MIMCAP_V021.lib.scs" section=typ
include "/usr/local/cadence6/G-9FD-MIXED_MODE_RFCMOS13-1P8M-MMC_FSG_L130E_UM130FDKMFC0000OA-FDK-Ver.A02_PB/umc13mmrf/../Models/Spectre/MML130E_MIMCAP_V121.lib.scs" section=typ
include "/usr/local/cadence6/G-9FD-MIXED_MODE_RFCMOS13-1P8M-MMC_FSG_L130E_UM130FDKMFC0000OA-FDK-Ver.A02_PB/umc13mmrf/../Models/Spectre/mm130e_mom_v031.lib.scs" section=typ
include "/usr/local/cadence6/G-9FD-MIXED_MODE_RFCMOS13-1P8M-MMC_FSG_L130E_UM130FDKMFC0000OA-FDK-Ver.A02_PB/umc13mmrf/../Models/Spectre/MML130E_RES_V152.lib.scs" section=res_typ
include "/usr/local/cadence6/G-9FD-MIXED_MODE_RFCMOS13-1P8M-MMC_FSG_L130E_UM130FDKMFC0000OA-FDK-Ver.A02_PB/umc13mmrf/../Models/Spectre/L130E_SP12_V141.lib.scs" section=tt
include "/usr/local/cadence6/G-9FD-MIXED_MODE_RFCMOS13-1P8M-MMC_FSG_L130E_UM130FDKMFC0000OA-FDK-Ver.A02_PB/umc13mmrf/../Models/Spectre/L130E_DIODE_V151.mdl.scs"
include "/usr/local/cadence6/G-9FD-MIXED_MODE_RFCMOS13-1P8M-MMC_FSG_L130E_UM130FDKMFC0000OA-FDK-Ver.A02_PB/umc13mmrf/../Models/Spectre/VIL/1P8M2T/l_cr20k_rfvil_V031.lib.scs" section=typ
include "/usr/local/cadence6/G-9FD-MIXED_MODE_RFCMOS13-1P8M-MMC_FSG_L130E_UM130FDKMFC0000OA-FDK-Ver.A02_PB/umc13mmrf/../Models/Spectre/VIL/1P8M2T/l_nwcr20k_rfvil_V031.lib.scs" section=typ
include "/usr/local/cadence6/G-9FD-MIXED_MODE_RFCMOS13-1P8M-MMC_FSG_L130E_UM130FDKMFC0000OA-FDK-Ver.A02_PB/umc13mmrf/../Models/Spectre/VIL/1P8M2T/l_nwsqsk_rfvil_V031.lib.scs" section=typ
include "/usr/local/cadence6/G-9FD-MIXED_MODE_RFCMOS13-1P8M-MMC_FSG_L130E_UM130FDKMFC0000OA-FDK-Ver.A02_PB/umc13mmrf/../Models/Spectre/VIL/1P8M2T/l_nwsy20kct_rfvil_V031.lib.scs" section=typ
include "/usr/local/cadence6/G-9FD-MIXED_MODE_RFCMOS13-1P8M-MMC_FSG_L130E_UM130FDKMFC0000OA-FDK-Ver.A02_PB/umc13mmrf/../Models/Spectre/VIL/1P8M2T/l_nwsy20k_rfvil_V031.lib.scs" section=typ
include "/usr/local/cadence6/G-9FD-MIXED_MODE_RFCMOS13-1P8M-MMC_FSG_L130E_UM130FDKMFC0000OA-FDK-Ver.A02_PB/umc13mmrf/../Models/Spectre/VIL/1P8M2T/l_sqsk_rfvil_V031.lib.scs" section=typ
include "/usr/local/cadence6/G-9FD-MIXED_MODE_RFCMOS13-1P8M-MMC_FSG_L130E_UM130FDKMFC0000OA-FDK-Ver.A02_PB/umc13mmrf/../Models/Spectre/VIL/1P8M2T/l_sy20kct_rfvil_V031.lib.scs" section=typ
include "/usr/local/cadence6/G-9FD-MIXED_MODE_RFCMOS13-1P8M-MMC_FSG_L130E_UM130FDKMFC0000OA-FDK-Ver.A02_PB/umc13mmrf/../Models/Spectre/VIL/1P8M2T/l_sy20k_rfvil_V031.lib.scs" section=typ

// myLib/NAND/schematic
subckt NAND GND IN1 IN2 NAND VDD
    PM1 (NAND IN2 VDD VDD) p_12_hsl130e w=2u l=120.00n m=(1)*(1) nf=1 mis_flag=1 mf=(1)*(1)
    PM0 (NAND IN1 VDD VDD) p_12_hsl130e w=2u l=120.00n m=(1)*(1) nf=1 mis_flag=1 mf=(1)*(1)
    NM1 (net19 IN2 GND GND) n_12_hsl130e w=1u l=120.0n m=(1)*(1) nf=1 mis_flag=1 mf=(1)*(1)
    NM2 (NAND IN1 net19 GND) n_12_hsl130e w=1u l=120.0n m=(1)*(1) nf=1 mis_flag=1 mf=(1)*(1)
ends NAND

// Project_Lib1/inv/schematic
subckt inv GND IN OUT VDD
    NM0 (OUT IN GND GND) n_12_hsl130e w=160.0n l=130.0n m=(1)*(1) nf=1 mis_flag=1 mf=(1)*(1)
    PM0 (OUT IN VDD VDD) p_12_hsl130e w=640.0n l=130.0n m=(1)*(1) nf=1 mis_flag=1 mf=(1)*(1)
ends inv

// Project_Lib1/binary/schematic
subckt binary A1 A2 A3 A4 A5 A6 A7 BC GND VDD
    I7 (GND net23 A5 net011 VDD) NAND
    I8 (GND net010 A6 net08 VDD) NAND
    I9 (GND net07 A7 BC VDD) NAND
    I3 (GND A1 A2 net20 VDD) NAND
    I2 (GND net016 A3 net17 VDD) NAND
    I1 (GND net014 A4 net18 VDD) NAND
    I14 (GND net08 net07 VDD) inv
    I13 (GND net011 net010 VDD) inv
    I12 (GND net18 net23 VDD) inv
    I10 (GND net20 net016 VDD) inv
    I11 (GND net17 net014 VDD) inv
ends binary

// Project_Lib1/asr/schematic
subckt asr ASR B1 B2 B3 B4 B5 B6 B7 DC GND VDD
    I0 (GND net9 DC ASR VDD) NAND
    I2 (B1 B2 B3 B4 B5 B6 B7 net9 GND VDD) binary
ends asr

// Project_Lib1/delay_chain/schematic
subckt delay_chain GND IN OUT VDD
    NM14 (OUT net0154 GND GND) n_12_hsl130e w=160.0n l=130.0n m=(1)*(1) nf=1 mis_flag=1 mf=(1)*(1)
    NM13 (net0154 net0152 GND GND) n_12_hsl130e w=160.0n l=130.0n m=(1)*(1) nf=1 mis_flag=1 mf=(1)*(1)
    NM12 (net0152 net0150 GND GND) n_12_hsl130e w=160.0n l=130.0n m=(1)*(1) nf=1 mis_flag=1 mf=(1)*(1)
    NM11 (net0150 net0148 GND GND) n_12_hsl130e w=160.0n l=130.0n m=(1)*(1) nf=1 mis_flag=1 mf=(1)*(1)
    NM10 (net0148 net0146 GND GND) n_12_hsl130e w=160.0n l=130.0n m=(1)*(1) nf=1 mis_flag=1 mf=(1)*(1)
    NM9 (net0146 net0144 GND GND) n_12_hsl130e w=160.0n l=130.0n m=(1)*(1) nf=1 mis_flag=1 mf=(1)*(1)
    NM8 (net0144 net0142 GND GND) n_12_hsl130e w=160.0n l=130.0n m=(1)*(1) nf=1 mis_flag=1 mf=(1)*(1)
    NM7 (net0142 net0140 GND GND) n_12_hsl130e w=160.0n l=130.0n m=(1)*(1) nf=1 mis_flag=1 mf=(1)*(1)
    NM6 (net0140 net0138 GND GND) n_12_hsl130e w=160.0n l=130.0n m=(1)*(1) nf=1 mis_flag=1 mf=(1)*(1)
    NM5 (net0138 net0135 GND GND) n_12_hsl130e w=160.0n l=130.0n m=(1)*(1) nf=1 mis_flag=1 mf=(1)*(1)
    NM3 (net0133 net038 GND GND) n_12_hsl130e w=160.0n l=130.0n m=(1)*(1) nf=1 mis_flag=1 mf=(1)*(1)
    NM4 (net0135 net0133 GND GND) n_12_hsl130e w=160.0n l=130.0n m=(1)*(1) nf=1 mis_flag=1 mf=(1)*(1)
    NM1 (net036 net033 GND GND) n_12_hsl130e w=160.0n l=130.0n m=(1)*(1) nf=1 mis_flag=1 mf=(1)*(1)
    NM2 (net038 net036 GND GND) n_12_hsl130e w=160.0n l=130.0n m=(1)*(1) nf=1 mis_flag=1 mf=(1)*(1)
    NM0 (net033 IN GND GND) n_12_hsl130e w=160.0n l=130.0n m=(1)*(1) nf=1 mis_flag=1 mf=(1)*(1)
    PM14 (OUT net0154 VDD VDD) p_12_hsl130e w=640.0n l=130.0n m=(1)*(1) nf=1 mis_flag=1 mf=(1)*(1)
    PM13 (net0154 net0152 VDD VDD) p_12_hsl130e w=640.0n l=130.0n m=(1)*(1) nf=1 mis_flag=1 mf=(1)*(1)
    PM12 (net0152 net0150 VDD VDD) p_12_hsl130e w=640.0n l=130.0n m=(1)*(1) nf=1 mis_flag=1 mf=(1)*(1)
    PM11 (net0150 net0148 VDD VDD) p_12_hsl130e w=640.0n l=130.0n m=(1)*(1) nf=1 mis_flag=1 mf=(1)*(1)
    PM10 (net0148 net0146 VDD VDD) p_12_hsl130e w=640.0n l=130.0n m=(1)*(1) nf=1 mis_flag=1 mf=(1)*(1)
    PM9 (net0146 net0144 VDD VDD) p_12_hsl130e w=640.0n l=130.0n m=(1)*(1) nf=1 mis_flag=1 mf=(1)*(1)
    PM8 (net0144 net0142 VDD VDD) p_12_hsl130e w=640.0n l=130.0n m=(1)*(1) nf=1 mis_flag=1 mf=(1)*(1)
    PM7 (net0142 net0140 VDD VDD) p_12_hsl130e w=640.0n l=130.0n m=(1)*(1) nf=1 mis_flag=1 mf=(1)*(1)
    PM6 (net0140 net0138 VDD VDD) p_12_hsl130e w=640.0n l=130.0n m=(1)*(1) nf=1 mis_flag=1 mf=(1)*(1)
    PM5 (net0138 net0135 VDD VDD) p_12_hsl130e w=640.0n l=130.0n m=(1)*(1) nf=1 mis_flag=1 mf=(1)*(1)
    PM1 (net036 net033 VDD VDD) p_12_hsl130e w=(640nM)/(1) l=130.0n m=(1)*(1) nf=1 mis_flag=1 mf=(1)*(1)
    PM4 (net0135 net0133 VDD VDD) p_12_hsl130e w=640.0n l=130.0n m=(1)*(1) nf=1 mis_flag=1 mf=(1)*(1)
    PM3 (net0133 net038 VDD VDD) p_12_hsl130e w=(640nM)/(1) l=130.0n m=(1)*(1) nf=1 mis_flag=1 mf=(1)*(1)
    PM2 (net038 net036 VDD VDD) p_12_hsl130e w=640.0n l=130.0n m=(1)*(1) nf=1 mis_flag=1 mf=(1)*(1)
    PM0 (net033 IN VDD VDD) p_12_hsl130e w=(640nM)/(1) l=130.0n m=(1)*(1) nf=1 mis_flag=1 mf=(1)*(1)
ends delay_chain

// Project_Lib1/comparator/schematic
subckt comparator GND IN OUT VDD
    NM0 (OUT IN GND GND) n_12_hsl130e w=160.0n l=130.0n m=(1)*(1) nf=1 mis_flag=1 mf=(1)*(1)
    PM0 (OUT IN VDD VDD) p_12_hsl130e w=640.0n l=130.0n m=(1)*(1) nf=1 mis_flag=1 mf=(1)*(1)
ends comparator

// Project_Lib1/photodiode/schematic
subckt photodiode N P
    D0 (P N) dionw_l130e area=1e-10 perim=(40u) m=1
ends photodiode

// Project_Lib1/reset/schematic
subckt reset ASR GR VDD VN
    PM1 (VN ASR VDD VDD) p_12_hsl130e w=3u l=360.0n m=(1)*(1) nf=1 mis_flag=1 mf=(1)*(1)
    PM0 (VN GR VDD VDD) p_12_hsl130e w=3u l=360.0n m=(1)*(1) nf=1 mis_flag=1 mf=(1)*(1)
ends reset

// Project_Lib1/integrated/schematic
subckt integrated B7 BHIGH GND GR VDD
    I0 (net12 BHIGH BHIGH BHIGH BHIGH BHIGH BHIGH B7 net11 GND VDD) asr
    I1 (GND net14 net11 VDD) delay_chain
    I2 (GND GND net14 VDD) comparator
    I3 (net13 GND) photodiode
    I4 (net12 GR VDD net13) reset
ends integrated

// Project_Lib1_sim/integrated_sim/schematic
I0 (net5 vdd! 0 net3 vdd!) integrated
V1 (net5 0) vsource type=pulse val0=0 val1=1.2 period=90u delay=89u rise=50n fall=50n width=1u
V0 (net3 0) vsource type=pulse val0=0 val1=1.2 period=100u delay=0 rise=50n fall=50n width=1u
simulatorOptions options temp=27
tran tran stop=200u errpreset=conservative
save V0:p V1:p
