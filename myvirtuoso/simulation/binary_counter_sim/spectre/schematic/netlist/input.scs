// Design: Project_Lib1_sim/binary_counter_sim
simulator lang=spectre
global 0
include "/usr/local/cadence6/G-9FD-MIXED_MODE_RFCMOS13-1P8M-MMC_FSG_L130E_UM130FDKMFC0000OA-FDK-Ver.A02_PB/umc13mmrf/../Models/Spectre/l130e-rf-v171-control.scs"
include "/usr/local/cadence6/G-9FD-MIXED_MODE_RFCMOS13-1P8M-MMC_FSG_L130E_UM130FDKMFC0000OA-FDK-Ver.A02_PB/umc13mmrf/../Models/Spectre/L130E_LL12_V141.lib.scs" section=tt
include "/usr/local/cadence6/G-9FD-MIXED_MODE_RFCMOS13-1P8M-MMC_FSG_L130E_UM130FDKMFC0000OA-FDK-Ver.A02_PB/umc13mmrf/../Models/Spectre/L130E_HG_LVT33_BPW_V131.lib.scs" section=tt
include "/usr/local/cadence6/G-9FD-MIXED_MODE_RFCMOS13-1P8M-MMC_FSG_L130E_UM130FDKMFC0000OA-FDK-Ver.A02_PB/umc13mmrf/../Models/Spectre/L130E_HG_RVT33_BPW_V131.lib.scs" section=tt
include "/usr/local/cadence6/G-9FD-MIXED_MODE_RFCMOS13-1P8M-MMC_FSG_L130E_UM130FDKMFC0000OA-FDK-Ver.A02_PB/umc13mmrf/../Models/Spectre/L130E_HS12_BPW_V241.lib.scs" section=tt
include "/usr/local/cadence6/G-9FD-MIXED_MODE_RFCMOS13-1P8M-MMC_FSG_L130E_UM130FDKMFC0000OA-FDK-Ver.A02_PB/umc13mmrf/../Models/Spectre/L130E_HS_LVT12_BPW_V031.lib.scs" section=tt
include "/usr/local/cadence6/G-9FD-MIXED_MODE_RFCMOS13-1P8M-MMC_FSG_L130E_UM130FDKMFC0000OA-FDK-Ver.A02_PB/umc13mmrf/../Models/Spectre/L130E_BJT_V141.lib.scs" section=typ_BIP
include "/usr/local/cadence6/G-9FD-MIXED_MODE_RFCMOS13-1P8M-MMC_FSG_L130E_UM130FDKMFC0000OA-FDK-Ver.A02_PB/umc13mmrf/../Models/Spectre/L130E_HG_LVT33_V131.lib.scs" section=tt
include "/usr/local/cadence6/G-9FD-MIXED_MODE_RFCMOS13-1P8M-MMC_FSG_L130E_UM130FDKMFC0000OA-FDK-Ver.A02_PB/umc13mmrf/../Models/Spectre/L130E_HG_NVT33_v031.lib.scs" section=tt
include "/usr/local/cadence6/G-9FD-MIXED_MODE_RFCMOS13-1P8M-MMC_FSG_L130E_UM130FDKMFC0000OA-FDK-Ver.A02_PB/umc13mmrf/../Models/Spectre/L130E_HG_RVT33_V131.lib.scs" section=tt
include "/usr/local/cadence6/G-9FD-MIXED_MODE_RFCMOS13-1P8M-MMC_FSG_L130E_UM130FDKMFC0000OA-FDK-Ver.A02_PB/umc13mmrf/../Models/Spectre/L130E_HS12_V241.lib.scs" section=tt
include "/usr/local/cadence6/G-9FD-MIXED_MODE_RFCMOS13-1P8M-MMC_FSG_L130E_UM130FDKMFC0000OA-FDK-Ver.A02_PB/umc13mmrf/../Models/Spectre/L130E_HS_LVT12_V031.lib.scs" section=tt
include "/usr/local/cadence6/G-9FD-MIXED_MODE_RFCMOS13-1P8M-MMC_FSG_L130E_UM130FDKMFC0000OA-FDK-Ver.A02_PB/umc13mmrf/../Models/Spectre/L130E_HS_NVT12_V041.lib.scs" section=tt
include "/usr/local/cadence6/G-9FD-MIXED_MODE_RFCMOS13-1P8M-MMC_FSG_L130E_UM130FDKMFC0000OA-FDK-Ver.A02_PB/umc13mmrf/../Models/Spectre/MML130E_20f_MIMCAP_V011.lib.scs" section=typ
include "/usr/local/cadence6/G-9FD-MIXED_MODE_RFCMOS13-1P8M-MMC_FSG_L130E_UM130FDKMFC0000OA-FDK-Ver.A02_PB/umc13mmrf/../Models/Spectre/MML130E_15f_MIMCAP_V021.lib.scs" section=typ
include "/usr/local/cadence6/G-9FD-MIXED_MODE_RFCMOS13-1P8M-MMC_FSG_L130E_UM130FDKMFC0000OA-FDK-Ver.A02_PB/umc13mmrf/../Models/Spectre/MML130E_MIMCAP_V121.lib.scs" section=typ
include "/usr/local/cadence6/G-9FD-MIXED_MODE_RFCMOS13-1P8M-MMC_FSG_L130E_UM130FDKMFC0000OA-FDK-Ver.A02_PB/umc13mmrf/../Models/Spectre/mm130e_mom_v031.lib.scs" section=typ
include "/usr/local/cadence6/G-9FD-MIXED_MODE_RFCMOS13-1P8M-MMC_FSG_L130E_UM130FDKMFC0000OA-FDK-Ver.A02_PB/umc13mmrf/../Models/Spectre/MML130E_RES_V152.lib.scs" section=res_typ
include "/usr/local/cadence6/G-9FD-MIXED_MODE_RFCMOS13-1P8M-MMC_FSG_L130E_UM130FDKMFC0000OA-FDK-Ver.A02_PB/umc13mmrf/../Models/Spectre/L130E_SP12_V141.lib.scs" section=tt
include "/usr/local/cadence6/G-9FD-MIXED_MODE_RFCMOS13-1P8M-MMC_FSG_L130E_UM130FDKMFC0000OA-FDK-Ver.A02_PB/umc13mmrf/../Models/Spectre/L130E_DIODE_V151.mdl.scs"
include "/usr/local/cadence6/G-9FD-MIXED_MODE_RFCMOS13-1P8M-MMC_FSG_L130E_UM130FDKMFC0000OA-FDK-Ver.A02_PB/umc13mmrf/../Models/Spectre/VIL/1P8M2T/l_cr20k_rfvil_V031.lib.scs" section=typ
include "/usr/local/cadence6/G-9FD-MIXED_MODE_RFCMOS13-1P8M-MMC_FSG_L130E_UM130FDKMFC0000OA-FDK-Ver.A02_PB/umc13mmrf/../Models/Spectre/VIL/1P8M2T/l_nwcr20k_rfvil_V031.lib.scs" section=typ
include "/usr/local/cadence6/G-9FD-MIXED_MODE_RFCMOS13-1P8M-MMC_FSG_L130E_UM130FDKMFC0000OA-FDK-Ver.A02_PB/umc13mmrf/../Models/Spectre/VIL/1P8M2T/l_nwsqsk_rfvil_V031.lib.scs" section=typ
include "/usr/local/cadence6/G-9FD-MIXED_MODE_RFCMOS13-1P8M-MMC_FSG_L130E_UM130FDKMFC0000OA-FDK-Ver.A02_PB/umc13mmrf/../Models/Spectre/VIL/1P8M2T/l_nwsy20kct_rfvil_V031.lib.scs" section=typ
include "/usr/local/cadence6/G-9FD-MIXED_MODE_RFCMOS13-1P8M-MMC_FSG_L130E_UM130FDKMFC0000OA-FDK-Ver.A02_PB/umc13mmrf/../Models/Spectre/VIL/1P8M2T/l_nwsy20k_rfvil_V031.lib.scs" section=typ
include "/usr/local/cadence6/G-9FD-MIXED_MODE_RFCMOS13-1P8M-MMC_FSG_L130E_UM130FDKMFC0000OA-FDK-Ver.A02_PB/umc13mmrf/../Models/Spectre/VIL/1P8M2T/l_sqsk_rfvil_V031.lib.scs" section=typ
include "/usr/local/cadence6/G-9FD-MIXED_MODE_RFCMOS13-1P8M-MMC_FSG_L130E_UM130FDKMFC0000OA-FDK-Ver.A02_PB/umc13mmrf/../Models/Spectre/VIL/1P8M2T/l_sy20kct_rfvil_V031.lib.scs" section=typ
include "/usr/local/cadence6/G-9FD-MIXED_MODE_RFCMOS13-1P8M-MMC_FSG_L130E_UM130FDKMFC0000OA-FDK-Ver.A02_PB/umc13mmrf/../Models/Spectre/VIL/1P8M2T/l_sy20k_rfvil_V031.lib.scs" section=typ

// Project_Lib1/dff/schematic
subckt dff CLK D GND Q VDD nQ nRST
    NM19 (net70 CLK net67 GND) n_12_hsl130e w=480.0n l=120.0n m=(1)*(1) nf=1 mis_flag=1 mf=(1)*(1)
    NM18 (net67 net11 GND GND) n_12_hsl130e w=480.0n l=120.0n m=(1)*(1) nf=1 mis_flag=1 mf=(1)*(1)
    NM22 (net65 net30 GND GND) n_12_hsl130e w=480.0n l=120.0n m=(1)*(1) nf=1 mis_flag=1 mf=(1)*(1)
    NM24 (net71 nQ GND GND) n_12_hsl130e w=320.0n l=120.0n m=(1)*(1) nf=1 mis_flag=1 mf=(1)*(1)
    NM23 (net66 CLK net65 GND) n_12_hsl130e w=480.0n l=120.0n m=(1)*(1) nf=1 mis_flag=1 mf=(1)*(1)
    NM28 (net68 nRST GND GND) n_12_hsl130e w=480.0n l=120.0n m=(1)*(1) nf=1 mis_flag=1 mf=(1)*(1)
    NM21 (net83 nRST net66 GND) n_12_hsl130e w=480.0n l=120.0n m=(1)*(1) nf=1 mis_flag=1 mf=(1)*(1)
    NM15 (net30 net11 net69 GND) n_12_hsl130e w=320.0n l=120.0n m=(1)*(1) nf=1 mis_flag=1 mf=(1)*(1)
    NM14 (net69 net83 GND GND) n_12_hsl130e w=320.0n l=120.0n m=(1)*(1) nf=1 mis_flag=1 mf=(1)*(1)
    NM20 (net79 net83 net70 GND) n_12_hsl130e w=480.0n l=120.0n m=(1)*(1) nf=1 mis_flag=1 mf=(1)*(1)
    NM25 (Q net83 net71 GND) n_12_hsl130e w=320.0n l=120.0n m=(1)*(1) nf=1 mis_flag=1 mf=(1)*(1)
    NM27 (net73 net79 net68 GND) n_12_hsl130e w=480.0n l=120.0n m=(1)*(1) nf=1 mis_flag=1 mf=(1)*(1)
    NM26 (nQ Q net73 GND) n_12_hsl130e w=480.0n l=120.0n m=(1)*(1) nf=1 mis_flag=1 mf=(1)*(1)
    NM2 (net11 nRST net72 GND) n_12_hsl130e w=480.0n l=120.0n m=(1)*(1) nf=1 mis_flag=1 mf=(1)*(1)
    NM1 (net72 D net74 GND) n_12_hsl130e w=480.0n l=120.0n m=(1)*(1) nf=1 mis_flag=1 mf=(1)*(1)
    NM0 (net74 net79 GND GND) n_12_hsl130e w=480.0n l=120.0n m=(1)*(1) nf=1 mis_flag=1 mf=(1)*(1)
    PM21 (net83 net30 VDD VDD) p_12_hsl130e w=320.0n l=120.0n m=(1)*(1) nf=1 mis_flag=1 mf=(1)*(1)
    PM20 (net83 CLK VDD VDD) p_12_hsl130e w=320.0n l=120.0n m=(1)*(1) nf=1 mis_flag=1 mf=(1)*(1)
    PM10 (net30 net11 VDD VDD) p_12_hsl130e w=320.0n l=120.0n m=(1)*(1) nf=1 mis_flag=1 mf=(1)*(1)
    PM9 (net30 net83 VDD VDD) p_12_hsl130e w=320.0n l=120.0n m=(1)*(1) nf=1 mis_flag=1 mf=(1)*(1)
    PM18 (net79 net83 VDD VDD) p_12_hsl130e w=320.0n l=120.0n m=(1)*(1) nf=1 mis_flag=1 mf=(1)*(1)
    PM26 (nQ nRST VDD VDD) p_12_hsl130e w=320.0n l=120.0n m=(1)*(1) nf=1 mis_flag=1 mf=(1)*(1)
    PM25 (nQ net79 VDD VDD) p_12_hsl130e w=320.0n l=120.0n m=(1)*(1) nf=1 mis_flag=1 mf=(1)*(1)
    PM2 (net11 net79 VDD VDD) p_12_hsl130e w=320.0n l=120.0n m=(1)*(1) nf=1 mis_flag=1 mf=(1)*(1)
    PM1 (net11 D VDD VDD) p_12_hsl130e w=320.0n l=120.0n m=(1)*(1) nf=1 mis_flag=1 mf=(1)*(1)
    PM0 (net11 nRST VDD VDD) p_12_hsl130e w=320.0n l=120.0n m=(1)*(1) nf=1 mis_flag=1 mf=(1)*(1)
    PM19 (net83 nRST VDD VDD) p_12_hsl130e w=320.0n l=120.0n m=(1)*(1) nf=1 mis_flag=1 mf=(1)*(1)
    PM17 (net79 CLK VDD VDD) p_12_hsl130e w=320.0n l=120.0n m=(1)*(1) nf=1 mis_flag=1 mf=(1)*(1)
    PM16 (net79 net11 VDD VDD) p_12_hsl130e w=320.0n l=120.0n m=(1)*(1) nf=1 mis_flag=1 mf=(1)*(1)
    PM23 (Q nQ VDD VDD) p_12_hsl130e w=320.0n l=120.0n m=(1)*(1) nf=1 mis_flag=1 mf=(1)*(1)
    PM22 (Q net83 VDD VDD) p_12_hsl130e w=320.0n l=120.0n m=(1)*(1) nf=1 mis_flag=1 mf=(1)*(1)
    PM24 (nQ Q VDD VDD) p_12_hsl130e w=320.0n l=120.0n m=(1)*(1) nf=1 mis_flag=1 mf=(1)*(1)
ends dff

// Project_Lib1/binary_counter/schematic
subckt binary_counter GND IN Q0 Q1 Q2 Q3 Q4 Q5 Q6 Q7 VDD nRST
    I13 (net43 net44 GND Q6 VDD net44 nRST) dff
    I12 (net44 net46 GND Q7 VDD net46 nRST) dff
    I11 (net41 net43 GND Q5 VDD net43 nRST) dff
    I10 (net39 net41 GND Q4 VDD net41 nRST) dff
    I9 (net36 net37 GND Q2 VDD net37 nRST) dff
    I8 (net37 net39 GND Q3 VDD net39 nRST) dff
    I1 (net34 net36 GND Q1 VDD net36 nRST) dff
    I0 (IN net34 GND Q0 VDD net34 nRST) dff
ends binary_counter

// Project_Lib1_sim/binary_counter_sim/schematic
I0 (0 IN Q0 Q1 Q2 Q3 Q4 Q5 Q6 Q7 net2 nRST) binary_counter
V1 (IN 0) vsource type=pulse val0=0 val1=1.2 period=1n delay=0 rise=10p fall=10p width=100.0p
V0 (nRST 0) vsource type=pulse val0=0 val1=1.2 period=270n delay=20n rise=10p fall=10p width=250n
V2 (net2 0) vsource dc=1.2 type=dc
C16 (Q0 0) capacitor c=1.0f
C15 (Q1 0) capacitor c=1.0f
C14 (Q2 0) capacitor c=1.0f
C13 (Q3 0) capacitor c=1.0f
C12 (Q4 0) capacitor c=1.0f
C11 (Q5 0) capacitor c=1.0f
C10 (Q6 0) capacitor c=1.0f
C0 (Q7 0) capacitor c=1.0f
simulatorOptions options temp=27
tran tran stop=270n errpreset=conservative
